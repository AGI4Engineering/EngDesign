// Design: ece483_sp23/tb_mp3
simulator lang=spectre
global 0
parameters cmrr_sim=0 VCM=0 VDD=1.8 VSS=0
include "/class/ece483/models/models_ece483"

// ece483_sp23/ota/schematic
subckt ota VDD VSS ibp10u vin vip vout
    N3 (ibp10u ibp10u VSS VSS) tsmc18dN w=9.675u l=4.32u m=1 region=sat
    N2 (net3 ibp10u VSS VSS) tsmc18dN w=9.675u l=4.32u m=12 region=sat
    N1 (vout vin net3 VSS) tsmc18dN w=16.29u l=3.96u m=6 region=sat
    N0 (net4 vip net3 VSS) tsmc18dN w=16.29u l=3.96u m=6 region=sat
    P1 (net4 net4 VDD VDD) tsmc18dP w=18.18u l=1.08u m=6 region=sat
    P0 (vout net4 VDD VDD) tsmc18dP w=18.18u l=1.08u m=6 region=sat
ends ota

// ece483_sp23/tb_mp3/schematic
__ECE483_SP23_OTA (VDD VSS ibp10u vin vip vout) ota
V3 (vin VSS) vsource dc=VCM mag=cmrr_sim type=dc
V2 (vip vin) vsource dc=0 mag=(1-cmrr_sim) type=dc
V1 (VDD VSS) vsource dc=VDD type=dc
V0 (VSS 0) vsource dc=VSS type=dc
C0 (vout VSS) capacitor c=2p
I2 (VDD ibp10u) isource dc=10u type=dc
simulatorOptions options temp=27
ac ac start=1 stop=1G
dcOp dc
