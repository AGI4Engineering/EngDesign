// Design: ece483_sp23/tb_mp3
simulator lang=spectre
global 0
parameters CL=2p VCM=0.9 VDD=1.8 VSS=0
include "/class/ece483/models/models_ece483"

// DUT GOES HERE

// ece483_sp23/tb_mp3/schematic
__ECE483_SP23_OTA2 (VDD VSS ibp10u_cm vin_cm vip_cm vout_cm) ota
__ECE483_SP23_OTA1 (VDD VSS ibp10u vin vip vout) ota
V5 (vip_cm vin_cm) vsource dc=0 type=dc
V4 (vin_cm VSS) vsource dc=VCM mag=1 type=dc
V3 (vin VSS) vsource dc=VCM mag=0 type=dc
V2 (vip vin) vsource dc=0 mag=1 type=dc
V1 (VDD VSS) vsource dc=VDD type=dc
V0 (VSS 0) vsource dc=VSS type=dc
C1 (vout_cm VSS) capacitor c=CL
C0 (vout VSS) capacitor c=CL
I4 (VDD ibp10u_cm) isource dc=10u type=dc
I2 (VDD ibp10u) isource dc=10u type=dc
simulatorOptions options temp=27
ac ac start=1 stop=1G dec=11
dcOp dc
