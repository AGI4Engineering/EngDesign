// Design: ece483_sp23/tb_mp4
simulator lang=spectre
global 0
parameters t_step=10n vstep=30m CL=1p VCM=0.6 VDD=1.4 VSS=0
include "/class/ece483/models/models_ece483"

// DUT GOES HERE

// ece483_sp23/tb_mp4/schematic
VSTB (vout vin) vsource dc=0 type=dc
V1 (VDD VSS) vsource dc=VDD type=dc
V0 (VSS 0) vsource dc=VSS type=dc
I2 (ibn10u VSS) isource dc=10u type=dc
C0 (vout VSS) capacitor c=CL
V2 (vip VSS) vsource dc=VCM type=pulse val0=VCM - vstep/2 val1=VCM + vstep/2 period=1 delay=t_step rise=1n fall=1n
__ECE483_SP23_FC (vout ibn10u VDD vin vip VSS) fc_ota
simulatorOptions options temp=27
dcOp dc
stb stb start=1 stop=2G dec=101 probe=VSTB localgnd=VSS
tran tran stop=200n errpreset=conservative
save __ECE483_SP23_FC:3
