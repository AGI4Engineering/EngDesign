// Design: ece483_sp23/tb_mp4
simulator lang=spectre
global 0
parameters vstep=0.03 t_step=1e-08 VSS=0 VDD=1.4 VCM=0.6 CL=1e-12
include "/class/ece483/models/models_ece483"

// MP4/fc_ota/schematic
subckt fc_ota vout ibn10u VDD vin vip VSS
M1 (vin vip VSS VSS) tsmc18dN w=600u l=1.8u
M2 (vout vin VSS VSS) tsmc18dN w=600u l=1.8u
M3 (vout vip VSS VSS) tsmc18dN w=600u l=1.8u
M4 (vip ibn10u VSS VSS) tsmc18dN w=70.02u l=3u
M5 (vout ibn10u VSS VSS) tsmc18dP w=180u l=1.8u
M6 (vin ibn10u VDD VDD) tsmc18dP w=180u l=1.8u
ends fc_ota
// Top-level instantiation

// ece483_sp23/tb_mp4/schematic
VSTB (vout vin) vsource dc=0 type=dc
V1 (VDD VSS) vsource dc=VDD type=dc
V0 (VSS 0) vsource dc=VSS type=dc
I2 (ibn10u VSS) isource dc=10u type=dc
C0 (vout VSS) capacitor c=CL
V2 (vip VSS) vsource dc=VCM type=pulse val0=VCM - vstep/2 val1=VCM + vstep/2 period=1 delay=t_step rise=1n fall=1n
__ECE483_SP23_FC (vout ibn10u VDD vin vip VSS) fc_ota
simulatorOptions options temp=27
stb stb start=1 stop=2G dec=101 probe=VSTB localgnd=VSS
dcOp dc
save __ECE483_SP23_FC:3
