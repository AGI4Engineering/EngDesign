// Design: ece483_sp23/tb_mp4_test
simulator lang=spectre
global 0
parameters t_step=10n vstep=300m CL=1p VCM=0.6 VDD=1.4 VSS=0
include "/class/ece483/models/models_ece483"

// ece483_sp23/fc_ota/schematic
subckt fc_ota vout ibn10u VDD vin vip VSS
    P7 (vcas_mirr_n ibn10u net8 VDD) tsmc18dP w=1.8u l=540.0n m=8 region=sat
    P6 (vbp_mirror ibn10u net6 VDD) tsmc18dP w=1.8u l=540.0n m=8 region=sat
    P27 (net6 vbp_mirror VDD VDD) tsmc18dP w=1.8u l=540.0n m=4 region=sat
    P18 (vs_p2 vip vsource VSS) tsmc18dP w=1.8u l=270.0n m=24 region=sat
    P5 (net7 vbp_mirror VDD VDD) tsmc18dP w=1.8u l=540.0n m=24 region=sat
    P17 (vs_p1 vin vsource VSS) tsmc18dP w=1.8u l=270.0n m=24 region=sat
    P4 (net8 vbp_mirror VDD VDD) tsmc18dP w=1.8u l=540.0n m=4 region=sat
    P8 (vsource ibn10u net7 VDD) tsmc18dP w=1.8u l=540.0n m=48 region=sat
    P13 (vg_p ibn10u net4 VDD) tsmc18dP w=1.8u l=540.0n m=8 region=sat
    P12 (vout ibn10u net1 VDD) tsmc18dP w=1.8u l=540.0n m=8 region=sat
    P11 (net1 vg_p VDD VDD) tsmc18dP w=1.8u l=180.0n m=2 region=sat
    P14 (net4 vg_p VDD VDD) tsmc18dP w=1.8u l=180.0n m=2 region=sat
    N4 (vout vcas_mirr_n vs_p1 VSS) tsmc18dN w=720.0n l=810.0n m=6 region=sat
    N7 (vs_p2 vmirr_n VSS VSS) tsmc18dN w=360.0n l=540.0n m=16 region=sat
    N8 (vs_p1 vmirr_n VSS VSS) tsmc18dN w=360.0n l=540.0n m=16 region=sat
    N3 (net9 vmirr_n VSS VSS) tsmc18dN w=360.0n l=540.0n m=4 region=sat
    N2 (vg_p vcas_mirr_n vs_p2 VSS) tsmc18dN w=720.0n l=810.0n m=6 region=sat
    N1 (vmirr_n vcas_mirr_n net9 VSS) tsmc18dN w=720.0n l=810.0n m=6 region=sat
    R1 (vbp_mirror ibn10u) resistor r=21K m=1
    R0 (vcas_mirr_n vmirr_n) resistor r=21K m=1
ends fc_ota

// ece483_sp23/tb_mp4_test/schematic
VSTB (vout net1) vsource dc=0 type=dc
V1 (VDD VSS) vsource dc=VDD type=dc
V0 (VSS 0) vsource dc=VSS type=dc
I2 (net4 VSS) isource dc=10u type=dc
C0 (vout VSS) capacitor c=CL
V2 (vip VSS) vsource dc=VCM type=pulse val0=VCM - vstep/2 val1=VCM + vstep/2 period=1 delay=t_step rise=1n fall=1n
__ECE483_SP23_FC (vout net4 VDD net1 vip VSS) fc_ota
simulatorOptions options temp=27
dcOp dc
stb stb start=1 stop=2G dec=101 probe=VSTB localgnd=VSS
tran tran stop=200n errpreset=conservative
save __ECE483_SP23_FC:3
